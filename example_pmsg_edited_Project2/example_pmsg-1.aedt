# Ansys Electronics Desktop project, version 2025.2
materials:
  M19-24G: permeability{HUnit=A_per_meter BUnit=tesla curve (0, 0) (22.28, 0.05) (25.46, 0.1) (31.83, 0.15) (47.74, 0.36) (63.66, 0.54) (79.57, 0.65) (159.15, 0.99) (318.3, 1.2) (477.46, 1.28) (636.61, 1.33) (795.77, 1.36) (1591.5, 1.44) (3183, 1.52) (4774.6, 1.58) (6366.1, 1.63) (7957.7, 1.67) (15915, 1.8) (31830, 1.9) (111407, 2) (190984, 2.1) (350138, 2.3) (509292, 2.5)} core_loss_type="Electrical Steel" core_loss_kc=4.3255556 mass_density=7650
  XG196/96: permeability{HUnit=A_per_meter BUnit=tesla curve (-690000, 0) (-663113.52, 0.048797862) (-635337.77, 0.097595724) (-606627.88, 0.14639359) (-576935.93, 0.19519145) (-546210.65, 0.24398931) (-514397.15, 0.29278717) (-481436.56, 0.34158503) (-447265.71, 0.39038289) (-411816.7, 0.43918076) (-375016.43, 0.48797862) (-333347.94, 0.54110533) (-291679.45, 0.5934675) (-250010.95, 0.64582967) (-208342.46, 0.69819184) (-166673.97, 0.75055402) (-125005.48, 0.80291619) (-83336.985, 0.85527836) (-41668.492, 0.90764053) (0, 0.96)}
  vacuum: permittivity=1
  M19-24G_2DSF0.950: permeability{HUnit=A_per_meter BUnit=tesla curve (0, 0) (22.28, 0.0475014) (25.46, 0.0950016) (31.83, 0.142502) (47.74, 0.342003) (63.66, 0.513004) (79.57, 0.617505) (159.15, 0.94051) (318.3, 1.14002) (477.46, 1.21603) (636.61, 1.26354) (795.77, 1.29205) (1591.5, 1.3681) (3183, 1.4442) (4774.6, 1.5013) (6366.1, 1.5489) (7957.7, 1.587) (15915, 1.711) (31830, 1.807) (111407, 1.907) (190984, 2.007) (350138, 2.207) (509292, 2.407) (2100830, 4.407)} core_loss_type="Electrical Steel" core_loss_kc=4.55322 mass_density=7267.5
  XG196/96_2DSF1.000_N: CoordinateSystemType=Cylindrical permeability=1 magnetic_coercivity{Magnitude=-726962A_per_meter DirComp1=1 DirComp2=0 DirComp3=0}
  XG196/96_2DSF1.000_S: CoordinateSystemType=Cylindrical permeability=1 magnetic_coercivity{Magnitude=-726962A_per_meter DirComp1=-1 DirComp2=0 DirComp3=0}
  copper: permeability=0.999991 conductivity=58000000 mass_density=8933

design Maxwell2DDesign1 (Maxwell 2D, Transient, XY geometry, model units mm)
options: ComputeTransientInductance ModelDepth=100mm
variables:
  fractions = 1
  delta = -36.274681deg
  conds = 1
  R1 = 0.0011324341ohm
  Le1 = 4.0791897e-08H
geometry:
  Band [vacuum] = user_primitive(RMxprt/Band, DiaGap=61mm, DiaYoke=38mm, Length=0mm, SegAngle=0deg, Fractions=1, HalfAxial=0, InfoCore=0)
  Shaft [vacuum] = user_primitive(RMxprt/Band, DiaGap=61mm, DiaYoke=38mm, Length=0mm, SegAngle=0deg, Fractions=1, HalfAxial=0, InfoCore=100)
  OuterRegion [vacuum] = user_primitive(RMxprt/Band, DiaGap=61mm, DiaYoke=100mm, Length=0mm, SegAngle=0deg, Fractions=fractions, HalfAxial=0, InfoCore=100)
  Tool = user_primitive(RMxprt/Band, DiaGap=61mm, DiaYoke=100mm, Length=0mm, SegAngle=0deg, Fractions=fractions, HalfAxial=0, InfoCore=1)
  Stator [M19-24G_2DSF0.950] = user_primitive(RMxprt/SlotCore, DiaGap=62mm, DiaYoke=100mm, Length=0mm, Skew=0deg, Slots=15, SlotType=1, Hs0=0.5mm, Hs01=0mm, Hs1=0mm, Hs2=3.3535445mm, Bs0=3mm, Bs1=8.4560309mm, Bs2=9.8816667mm, Rs=4.9408334mm, FilletType=0, HalfSlot=0, SegAngle=15deg, LenRegion=0mm, InfoCore=0)
  Coil_0 [copper] = user_primitive(RMxprt/LapCoil, DiaGap=62mm, DiaYoke=100mm, Length=0mm, Skew=0deg, Slots=15, SlotType=1, Hs0=0.5mm, Hs1=0mm, Hs2=3.3535445mm, Bs0=3mm, Bs1=8.4560309mm, Bs2=9.8816667mm, Rs=4.9408334mm, FilletType=0, Layers=2, CoilPitch=1, EndExt=0mm, SpanExt=0mm, BendAngle=0deg, SegAngle=10deg, LenRegion=0mm, InfoCoil=2)
  Coil_1..Coil_14 [copper] = Coil_0.duplicate_around_axis(axis=Z, angle=24deg, total=15)
  CoilRe_0 [copper] = user_primitive(RMxprt/LapCoil, DiaGap=62mm, DiaYoke=100mm, Length=0mm, Skew=0deg, Slots=15, SlotType=1, Hs0=0.5mm, Hs1=0mm, Hs2=3.3535445mm, Bs0=3mm, Bs1=8.4560309mm, Bs2=9.8816667mm, Rs=4.9408334mm, FilletType=0, Layers=2, CoilPitch=1, EndExt=0mm, SpanExt=0mm, BendAngle=0deg, SegAngle=10deg, LenRegion=0mm, InfoCoil=3)
  CoilRe_0.rotate(axis=Z, angle=-24deg)
  CoilRe_1..CoilRe_14 [copper] = CoilRe_0.duplicate_around_axis(axis=Z, angle=24deg, total=15)
  Rotor [M19-24G_2DSF0.950] = user_primitive(RMxprt/PMCore, DiaGap=60mm, DiaYoke=38mm, Length=0mm, Poles=8, PoleType=1, Embrace=0.7, ThickMag=4mm, WidthMag=0mm, Offset=0mm, Bridge=0mm, Rib=0mm, LenRegion=0mm, InfoCore=0)
  Mag_0 [XG196/96_2DSF1.000_N] = user_primitive(RMxprt/PMCore, DiaGap=60mm, DiaYoke=38mm, Length=0mm, Poles=8, PoleType=1, Embrace=0.7, ThickMag=4mm, WidthMag=0mm, Offset=0mm, Bridge=0mm, Rib=0mm, LenRegion=0mm, InfoCore=2)
  Mag_1 [XG196/96_2DSF1.000_S], Mag_2 [XG196/96_2DSF1.000_N], Mag_3 [XG196/96_2DSF1.000_S], Mag_4 [XG196/96_2DSF1.000_N], Mag_5 [XG196/96_2DSF1.000_S], Mag_6 [XG196/96_2DSF1.000_N], Mag_7 [XG196/96_2DSF1.000_S] = Mag_0.duplicate_around_axis(axis=Z, angle=45deg, total=8)
  InnerRegion [vacuum] = user_primitive(RMxprt/PMCore, DiaGap=60mm, DiaYoke=38mm, Length=0mm, Poles=8, PoleType=1, Embrace=0.7, ThickMag=4mm, WidthMag=0mm, Offset=0mm, Bridge=0mm, Rib=0mm, LenRegion=0mm, InfoCore=100)
  Tool_1 = Tool.copy()
  Band.subtract(Tool_1)
  Tool_2 = Tool.copy()
  InnerRegion.subtract(Tool_2)
  Tool_3 = Tool.copy()
  Shaft.subtract(Tool_3)
  Tool_4 = Tool.copy()
  Stator.subtract(Tool_4)
  Tool_5 = Tool.copy()
  Coil_0.subtract(Tool_5)
  Tool_6 = Tool.copy()
  Coil_1.subtract(Tool_6)
  Tool_7 = Tool.copy()
  Coil_2.subtract(Tool_7)
  Tool_8 = Tool.copy()
  Coil_3.subtract(Tool_8)
  Tool_9 = Tool.copy()
  Coil_4.subtract(Tool_9)
  Tool_10 = Tool.copy()
  Coil_5.subtract(Tool_10)
  Tool_11 = Tool.copy()
  Coil_6.subtract(Tool_11)
  Tool_12 = Tool.copy()
  Coil_7.subtract(Tool_12)
  Tool_13 = Tool.copy()
  Coil_8.subtract(Tool_13)
  Tool_14 = Tool.copy()
  Coil_9.subtract(Tool_14)
  Tool_15 = Tool.copy()
  Coil_10.subtract(Tool_15)
  Tool_16 = Tool.copy()
  Coil_11.subtract(Tool_16)
  Tool_17 = Tool.copy()
  Coil_12.subtract(Tool_17)
  Tool_18 = Tool.copy()
  Coil_13.subtract(Tool_18)
  Tool_19 = Tool.copy()
  Coil_14.subtract(Tool_19)
  Tool_20 = Tool.copy()
  CoilRe_0.subtract(Tool_20)
  Tool_21 = Tool.copy()
  CoilRe_1.subtract(Tool_21)
  Tool_22 = Tool.copy()
  CoilRe_2.subtract(Tool_22)
  Tool_23 = Tool.copy()
  CoilRe_3.subtract(Tool_23)
  Tool_24 = Tool.copy()
  CoilRe_4.subtract(Tool_24)
  Tool_25 = Tool.copy()
  CoilRe_5.subtract(Tool_25)
  Tool_26 = Tool.copy()
  CoilRe_6.subtract(Tool_26)
  Tool_27 = Tool.copy()
  CoilRe_7.subtract(Tool_27)
  Tool_28 = Tool.copy()
  CoilRe_8.subtract(Tool_28)
  Tool_29 = Tool.copy()
  CoilRe_9.subtract(Tool_29)
  Tool_30 = Tool.copy()
  CoilRe_10.subtract(Tool_30)
  Tool_31 = Tool.copy()
  CoilRe_11.subtract(Tool_31)
  Tool_32 = Tool.copy()
  CoilRe_12.subtract(Tool_32)
  Tool_33 = Tool.copy()
  CoilRe_13.subtract(Tool_33)
  Tool_34 = Tool.copy()
  CoilRe_14.subtract(Tool_34)
  Tool_35 = Tool.copy()
  Rotor.subtract(Tool_35)
  Tool_36 = Tool.copy()
  Mag_0.subtract(Tool_36)
  Tool_37 = Tool.copy()
  Mag_1.subtract(Tool_37)
  Tool_38 = Tool.copy()
  Mag_2.subtract(Tool_38)
  Tool_39 = Tool.copy()
  Mag_3.subtract(Tool_39)
  Tool_40 = Tool.copy()
  Mag_4.subtract(Tool_40)
  Tool_41 = Tool.copy()
  Mag_5.subtract(Tool_41)
  Tool_42 = Tool.copy()
  Mag_6.subtract(Tool_42)
  Mag_7.subtract(Tool)
  Polyline1 [non-model] = polyline(z=0mm, xy in mm: (-28, 0) (-25.868627, -10.715136) (-19.79899, -19.79899), AngularArc from point 0 over 3 centre=(0mm, 0mm, 0mm) angle=45deg plane=XY)
motion:
  MotionSetup1: Band Move_Type=Rotate Coordinate_System=Global Axis=Z Is_Positive=true InitPos=1.5deg Angular_Velocity=1500rpm Objects=Band
  Moving1: Moving Objects=[Shaft, Rotor, Mag_0..Mag_7, InnerRegion]
boundaries and excitations:
  VectorPotential1: Vector Potential Edges=OuterRegion.edge(at (0, -50, 0)) Value=0
  PhA_0: Coil Objects=Coil_0 Conductor_number=conds Winding=PhaseA PolarityType=Positive
  PhARe_0: Coil Objects=CoilRe_1 Conductor_number=conds Winding=PhaseA PolarityType=Negative
  PhB_1: Coil Objects=Coil_1 Conductor_number=conds Winding=PhaseB PolarityType=Positive
  PhBRe_1: Coil Objects=CoilRe_2 Conductor_number=conds Winding=PhaseB PolarityType=Negative
  PhARe_2: Coil Objects=Coil_2 Conductor_number=conds Winding=PhaseA PolarityType=Negative
  PhA_2: Coil Objects=CoilRe_3 Conductor_number=conds Winding=PhaseA PolarityType=Positive
  PhBRe_3: Coil Objects=Coil_3 Conductor_number=conds Winding=PhaseB PolarityType=Negative
  PhB_3: Coil Objects=CoilRe_4 Conductor_number=conds Winding=PhaseB PolarityType=Positive
  PhA_4: Coil Objects=Coil_4 Conductor_number=conds Winding=PhaseA PolarityType=Positive
  PhARe_4: Coil Objects=CoilRe_5 Conductor_number=conds Winding=PhaseA PolarityType=Negative
  PhB_5: Coil Objects=Coil_5 Conductor_number=conds Winding=PhaseB PolarityType=Positive
  PhBRe_5: Coil Objects=CoilRe_6 Conductor_number=conds Winding=PhaseB PolarityType=Negative
  PhC_6: Coil Objects=Coil_6 Conductor_number=conds Winding=PhaseC PolarityType=Positive
  PhCRe_6: Coil Objects=CoilRe_7 Conductor_number=conds Winding=PhaseC PolarityType=Negative
  PhBRe_7: Coil Objects=Coil_7 Conductor_number=conds Winding=PhaseB PolarityType=Negative
  PhB_7: Coil Objects=CoilRe_8 Conductor_number=conds Winding=PhaseB PolarityType=Positive
  PhCRe_8: Coil Objects=Coil_8 Conductor_number=conds Winding=PhaseC PolarityType=Negative
  PhC_8: Coil Objects=CoilRe_9 Conductor_number=conds Winding=PhaseC PolarityType=Positive
  PhB_9: Coil Objects=Coil_9 Conductor_number=conds Winding=PhaseB PolarityType=Positive
  PhBRe_9: Coil Objects=CoilRe_10 Conductor_number=conds Winding=PhaseB PolarityType=Negative
  PhC_10: Coil Objects=Coil_10 Conductor_number=conds Winding=PhaseC PolarityType=Positive
  PhCRe_10: Coil Objects=CoilRe_11 Conductor_number=conds Winding=PhaseC PolarityType=Negative
  PhA_11: Coil Objects=Coil_11 Conductor_number=conds Winding=PhaseA PolarityType=Positive
  PhARe_11: Coil Objects=CoilRe_12 Conductor_number=conds Winding=PhaseA PolarityType=Negative
  PhCRe_12: Coil Objects=Coil_12 Conductor_number=conds Winding=PhaseC PolarityType=Negative
  PhC_12: Coil Objects=CoilRe_13 Conductor_number=conds Winding=PhaseC PolarityType=Positive
  PhARe_13: Coil Objects=Coil_13 Conductor_number=conds Winding=PhaseA PolarityType=Negative
  PhA_13: Coil Objects=CoilRe_14 Conductor_number=conds Winding=PhaseA PolarityType=Positive
  PhC_14: Coil Objects=Coil_14 Conductor_number=conds Winding=PhaseC PolarityType=Positive
  PhCRe_14: Coil Objects=CoilRe_0 Conductor_number=conds Winding=PhaseC PolarityType=Negative
  PhaseA: Winding Group Type=Voltage IsSolid=false Current=0A Resistance=R1 Inductance=Le1 Voltage=67.8823*sin(2*pi*100*time+delta) ParallelBranchesNum=1
  PhaseB: Winding Group Type=Voltage IsSolid=false Current=0A Resistance=R1 Inductance=Le1 Voltage=67.8823*sin(2*pi*100*time+delta-2*pi/3) ParallelBranchesNum=1
  PhaseC: Winding Group Type=Voltage IsSolid=false Current=0A Resistance=R1 Inductance=Le1 Voltage=67.8823*sin(2*pi*100*time+delta-4*pi/3) ParallelBranchesNum=1
mesh:
  SurfApprox_Mag: SurfApproxBased Objects=[Mag_0..Mag_7] CurvedSurfaceApproxChoice=ManualSettings SurfDev=0.03mm NormalDev=15deg
  SurfApprox_Main: SurfApproxBased Objects=[Stator, Rotor, Band, OuterRegion, InnerRegion, Shaft] CurvedSurfaceApproxChoice=ManualSettings SurfDev=0.05mm NormalDev=15deg
  CylindricalGap1: CylindricalGap Objects=Band Objects=Band
setups:
  Setup1: Transient NonlinearSolverResidual=0.0001 StopTime=0.1s TimeStep=0.0001s OutputPerObjectCoreLoss SaveFieldsType="Every N Steps" N_Steps=1 Steps_From=0s Steps_To=1ms NumberSolveSteps=1 RangeStart=0s RangeEnd=0.1s InitialTimeStep=0.002s MinTimeStep=0.001s MaxTimeStep=0.003s TimeStepErrTolerance=0.0001
output variables:
  pos = (Moving1.Position -1.5 * PI/180) * 4 + PI
  cos0 = cos(pos)
  cos1 = cos(pos-2*PI/3)
  cos2 = cos(pos-4*PI/3)
  sin0 = -sin(pos)
  sin1 = -sin(pos-2*PI/3)
  sin2 = -sin(pos-4*PI/3)
  Lad = L(PhaseA,PhaseA)*cos0 + L(PhaseA,PhaseB)*cos1 + L(PhaseA,PhaseC)*cos2
  Laq = L(PhaseA,PhaseA)*sin0 + L(PhaseA,PhaseB)*sin1 + L(PhaseA,PhaseC)*sin2
  Lbd = L(PhaseB,PhaseA)*cos0 + L(PhaseB,PhaseB)*cos1 + L(PhaseB,PhaseC)*cos2
  Lbq = L(PhaseB,PhaseA)*sin0 + L(PhaseB,PhaseB)*sin1 + L(PhaseB,PhaseC)*sin2
  Lcd = L(PhaseC,PhaseA)*cos0 + L(PhaseC,PhaseB)*cos1 + L(PhaseC,PhaseC)*cos2
  Lcq = L(PhaseC,PhaseA)*sin0 + L(PhaseC,PhaseB)*sin1 + L(PhaseC,PhaseC)*sin2
  L_d = (Lad*cos0 + Lbd*cos1 + Lcd*cos2) * 2/3
  L_q = (Laq*sin0 + Lbq*sin1 + Lcq*sin2) * 2/3
  Flux_d = (FluxLinkage(PhaseA)*cos0+FluxLinkage(PhaseB)*cos1+FluxLinkage(PhaseC)*cos2)*2/3
  Flux_q = (FluxLinkage(PhaseA)*sin0+FluxLinkage(PhaseB)*sin1+FluxLinkage(PhaseC)*sin2)*2/3
  I_d = (Current(PhaseA)*cos0 + Current(PhaseB)*cos1 + Current(PhaseC)*cos2)*2/3
  I_q = (Current(PhaseA)*sin0 + Current(PhaseB)*sin1 + Current(PhaseC)*sin2)*2/3
  Irms = sqrt(I_d^2+I_q^2)/sqrt(2.0)
  Pcu = 3*Irms^2*R1
field plots:
  Flux_Lines1: A over Stator on Setup1 : Transient at Time=0.1s
  Mag_B1: B over Stator on Setup1 : Transient at Time=100ms
  B_Vector1: B over Rotor, Stator, Mag_0, Mag_2, Mag_4, Mag_6, Mag_1, Mag_3, Mag_5, Mag_7, Band, InnerRegion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 on Setup1 : Transient at Time=0.1s
  Flux_Lines2: A over Rotor, Stator, Band, InnerRegion, OuterRegion, Shaft, Mag_0, Mag_2, Mag_4, Mag_6, Mag_1, Mag_3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 on Setup1 : Transient at Time=0.1s
reports:
  Torque: Moving1.Torque vs Time on Setup1 : Transient
  Currents: Current(PhaseA), Current(PhaseB), Current(PhaseC) vs Time on Setup1 : Transient
  Induced Voltages: InducedVoltage(PhaseA), InducedVoltage(PhaseB), InducedVoltage(PhaseC) vs Time on Setup1 : Transient
  Flux Linkages: FluxLinkage(PhaseA), FluxLinkage(PhaseB), FluxLinkage(PhaseC) vs Time on Setup1 : Transient
  Voltages: InputVoltage(PhaseA), InputVoltage(PhaseB), InputVoltage(PhaseC) vs Time on Setup1 : Transient
  Powers: InputVoltage(PhaseA)*Current(PhaseA) + InputVoltage(PhaseB)*Current(PhaseB) + InputVoltage(PhaseC)*Current(PhaseC), Moving1.Speed*Moving1.Torque vs Time on Setup1 : Transient
  L_dq: L_d, L_q vs Time on Setup1 : Transient
  Flux_dq: Flux_d, Flux_q vs Time on Setup1 : Transient
  I_dq: I_d, I_q vs Time on Setup1 : Transient

design pmsg-1 (RMxprt, Adjust-Speed Synchronous Machine, model units mm)
machine:
  Machine: FrictionLoss=12W WindLoss=0W ReferenceSpeed=1500rpm NumberOfPoles=8 RotorPosition=true ControlType=3 CircuitType=L3
  Stator: SkewWidth=0 NumberOfSlots=15 LaminationSectors=0 PressBoardThickness=0mm OuterDiameter=100mm InnerDiameter=62mm Length=100mm StackingFactor=0.95 SteelType=M19-24G SlotType=1
  Rotor: OuterDiameter=60mm InnerDiameter=38mm Length=100mm SteelType=M19-24G PoleType=1 StackingFactor=0.95
  Shaft:
  Stator Slot: Hs0=0.5mm Hs1=0mm Hs2=0mm Bs0=3mm Bs1=0mm Bs2=0mm Rs=0mm AutoDesign ToothWidth=0mm
  Stator Winding: WindingType=Editor WindingLayers=2 ParallelBranches=1 ConductorsPerSlot=2 CoilPitch=1 EndAdjustment=0mm BaseInnerRadius=0mm TipInnerDiameter=0mm EndClearance=0mm CoilWrap=0mm SlotLiner=0.3mm WedgeThickness=0mm LayerInsulation=0mm BottomInsulation=0mm LimitedFillFactor=0.75 WdgNumberofPriodicMultipler=1 WdgConstantTurns Wdgcoil_turns(1, 1, 1, 1, 1, 1, 1, 1, 1, 1, 1, 1, 1, 1, 1) Wdgcoil_name(A, B, -A, -B, A, B, C, -B, -C, B, C, A, -C, -A, C) Wdgcoil_go(1T, 2T, 3T, 4T, 5T, 6T, 7T, 8T, 9T, 10T, 11T, 12T, 13T, 14T, 15T) Wdgcoil_re(2B, 3B, 4B, 5B, 6B, 7B, 8B, 9B, 10B, 11B, 12B, 13B, 14B, 15B, 1B) NumberOfStrands=0 WireWrap=0mm InterturnInsulation=0mm WireDiameter=0mm WireWidth=0mm WireThickness=0mm Gauge=0
  Rotor Pole: Embrace=0.7 Offset=0mm ShaftDiameter=0mm Bridge=0mm Rib=0mm MagnetThickness=4mm MagnetWidth=0mm MagnetType=XG196/96
setups:
  Setup1: ASSM Motor RatedOutputPower=550W RatedVoltage=48V RatedSpeed=1500rpm OperatingTemperature=50cel LoadType=ConstPower RatedPowerFactor=1
